// Copyright 2022 ETH Zurich and University of Bologna.
// Solderpad Hardware License, Version 0.51, see LICENSE for details.
// SPDX-License-Identifier: SHL-0.51
// Licensed under Solderpad Hardware License, Version 0.51

// Axel Vanoni <axvanoni@student.ethz.ch>

{
	name: idma_desc64
	regwidth: 64
	clock_primary: clk_i
	bus_interfaces: [
		{
			protocol: reg_iface
			direction: device
		}
	]
	registers: [
		{
			name: desc_addr
			desc:
			'''
			This register specifies the bus address at which the first transfer
			descriptor can be found. A write to this register starts the transfer.
			'''
			swaccess: wo
			hwaccess: hro
			hwqe: true
			resval: 0xFFFFFFFFFFFFFFFF
			fields: [
				{
					bits: "63:0"
				}
			]
		}
		{
			name: status
			desc:
			'''
			This register contains status information for the DMA.
			'''
			swaccess: ro
			hwaccess: hwo
			resval: 0
			fields: [
				{
					name: "busy"
					desc:
					'''
					The DMA is busy
					'''
					bits: "0"
				}
				{
					name: "fifo_full"
					desc:
					'''
					If this bit is set, the buffers of the DMA are full. Any further submissions via the
					desc_addr register may overwrite previously submitted jobs or get lost.
					'''
					bits: "1"
				}
			]
		}
	]
}
