// Copyright 2025 ETH Zurich and University of Bologna.
// Solderpad Hardware License, Version 0.51, see LICENSE for details.
// SPDX-License-Identifier: SHL-0.51

// Authors:
// - Michael Rogenmoser <michaero@iis.ee.ethz.ch>
// - Thomas Benz <tbenz@iis.ee.ethz.ch>

`ifndef IDMA_REG_REG_RDL
`define IDMA_REG_REG_RDL

property rd_swacc {
    type = boolean;
    component = field;
};

addrmap idma_reg #(
    longint unsigned SysAddrWidth = 32, // Address width
    longint unsigned NumDims = 2, // Number of dimensions available
    longint unsigned Log2NumDims = 0, // Log2 of NumDims
    longint unsigned NumProtBits = 3 // Number of protocol bits
) {
    default regwidth = 32;

    reg conf {
        regwidth = 32;
        name = "conf";
        desc = "Configuration Register for DMA settings";
        default sw = rw;
        default hw = r;
        field {
            desc = "Decouple R-AW";
        } decouple_aw [0:0] = 0;
        field {
            desc = "Decouple R-W";
        } decouple_rw [1:1] = 0;
        field {
            desc = "Reduce maximal source burst length";
        } src_reduce_len [2:2] = 0;
        field {
            desc = "Reduce maximal destination burst length";
        } dst_reduce_len [3:3] = 0;
        field {
            desc = "Maximal logarithmic source burst length";
        } src_max_llen [6:4] = 0;
        field {
            desc = "Maximal logarithmic destination burst length";
        } dst_max_llen [9:7] = 0;
        field {
            desc = "ND-extension enabled";
        } enable_nd [10+Log2NumDims:10] = 0;
        field {
            desc = "Selection of the source protocol";
         } src_protocol [NumProtBits+11+Log2NumDims-1:11+Log2NumDims] = 0;
        field {
            desc = "Selection of the destination protocol";
         } dst_protocol [2*NumProtBits+11+Log2NumDims-1:11+Log2NumDims+NumProtBits] = 0;
    };

    reg status {
        regwidth = 32;
        name = "status";
        desc = "DMA Status";
        default sw = r;
        default hw = w;
        field {
            desc = "DMA busy";
        } busy [9:0] = 0;
    };

    reg next_id {
        regwidth = 32;
        name = "next_id";
        desc = "Next ID, launches transfer, returns 0 if transfer not set up properly.";
        default sw = r;
        default hw = w;
        field {
            desc = "Next ID, launches transfer, returns 0 if transfer not set up properly.";
            rd_swacc = true;
        } next_id [31:0] = 0;
    };

    reg done_id {
        regwidth = 32;
        name = "done_id";
        desc = "Get ID of finished transactions.";
        default sw = r;
        default hw = w;
        field {
            desc = "Get ID of finished transactions.";
        } done_id [31:0] = 0;
    };

    reg dst_addr {
        name = "dst_addr";
        desc = "Destination address";
        default sw = rw;
        default hw = r;
        field {
            desc = "Destination address";
        } dst_addr [31:0] = 0;
    };

    reg src_addr {
        name = "src_addr";
        desc = "Source address";
        default sw = rw;
        default hw = r;
        field {
            desc = "Source address";
        } src_addr [31:0] = 0;
    };

    reg length {
        name = "length";
        desc = "Transfer length in bytes";
        default sw = rw;
        default hw = r;
        field {
            desc = "Transfer length in bytes";
        } length [31:0] = 0;
    };

    reg dst_stride {
        name = "dst_stride";
        desc = "Destination stride";
        default sw = rw;
        default hw = r;
        field {
            desc = "Destination stride";
        } dst_stride [31:0] = 0;
    };

    reg src_stride {
        name = "src_stride";
        desc = "Source stride";
        default sw = rw;
        default hw = r;
        field {
            desc = "Source stride";
        } src_stride [31:0] = 0;
    };

    reg reps {
        name = "reps";
        desc = "Number of repetitions";
        default sw = rw;
        default hw = r;
        field {
            desc = "Number of repetitions";
        } reps [31:0] = 0;
    };

    // Single source of the compute op encoding: idma_pkg::compute_op_e and the
    // generated SW headers both derive from it.
    enum compute_op {
        none           = 4'd0 { desc = "No compute (plain copy)."; };
        transpose      = 4'd1 { desc = "Tiled transpose."; };
        mxquant        = 4'd2 { desc = "MX quant, FP32 source (128B -> 33B per 32-element block)."; };
        mxquant_fp16   = 4'd3 { desc = "MX quant, FP16 source (64B -> 33B per 32-element block)."; };
        mxdequant      = 4'd4 { desc = "MX dequant, FP32 destination (33B -> 128B per 32-element block)."; };
        mxdequant_fp16 = 4'd5 { desc = "MX dequant, FP16 destination (33B -> 64B per 32-element block)."; };
        alu            = 4'd6 { desc = "Byte-wise SIMD ALU; the function is selected in compute_alu."; };
        cast_fp32_i8   = 4'd7 { desc = "Element cast FP32 -> INT8, round to nearest even, saturating (4B -> 1B)."; };
        cast_fp32_i16  = 4'd8 { desc = "Element cast FP32 -> INT16, round to nearest even, saturating (4B -> 2B)."; };
        cast_fp32_bf16 = 4'd9 { desc = "Element cast FP32 -> BF16, round to nearest even (4B -> 2B)."; };
        cast_bf16_i8   = 4'd10 { desc = "Element cast BF16 -> INT8, round to nearest even, saturating (2B -> 1B)."; };
        cast_bf16_i16  = 4'd11 { desc = "Element cast BF16 -> INT16, round to nearest even, saturating (2B -> 2B)."; };
        cast_bf16_fp32 = 4'd12 { desc = "Element cast BF16 -> FP32, exact (2B -> 4B)."; };
        cast_fp16_fp32 = 4'd13 { desc = "Element cast FP16 -> FP32, exact (2B -> 4B)."; };
    };

    // Byte-wise ALU function (idma_pkg::alu_func_e): 8-bit lanes, wrapping arithmetic
    enum alu_func {
        not  = 4'd0 { desc = "y = ~x"; };
        addi = 4'd1 { desc = "y = x + imm"; };
        subi = 4'd2 { desc = "y = x - imm"; };
        muli = 4'd3 { desc = "y = x * imm (needs the alu_mul feature)"; };
        andi = 4'd4 { desc = "y = x & imm"; };
        ori  = 4'd5 { desc = "y = x | imm"; };
        xori = 4'd6 { desc = "y = x ^ imm"; };
        add  = 4'd8 { desc = "y = a + b (two operand streams)"; };
        sub  = 4'd9 { desc = "y = a - b (two operand streams)"; };
        mul  = 4'd10 { desc = "y = a * b (two operand streams, needs the alu_mul feature)"; };
        and  = 4'd11 { desc = "y = a & b (two operand streams)"; };
        or   = 4'd12 { desc = "y = a | b (two operand streams)"; };
        xor  = 4'd13 { desc = "y = a ^ b (two operand streams)"; };
        axpy = 4'd14 { desc = "y = imm * a + b (two operand streams, needs the alu_mul feature)"; };
    };

    reg compute_cfg {
        name = "compute_cfg";
        desc = "Per-transfer on-the-fly compute configuration. The fields are sampled when next_id is read to launch a transfer.";
        default sw = rw;
        default hw = r;
        field {
            desc = "Enable on-the-fly compute for the launched transfer.";
        } compute_enable [0:0] = 0;
        field {
            desc = "Compute operation selector (idma_pkg::compute_op_e).";
            encode = compute_op;
        } compute_op [4:1] = 0;
        field {
            desc = "Transpose element-size mode. The element size is 1 << transpose_mode bytes, encoding 8b, 16b, 32b, and 64b elements.";
        } transpose_mode [6:5] = 0;
        field {
            desc = "Transpose tensor M dimension in elements. Must be non-zero when transpose is enabled.";
        } transpose_tensor_m [18:7] = 0;
        field {
            desc = "Transpose tensor N dimension in elements. Must be non-zero when transpose is enabled.";
        } transpose_tensor_n [30:19] = 0;
        field {
            desc = "Reserved.";
        } reserved [31:31] = 0;
    };

    reg compute_alu {
        name = "compute_alu";
        desc = "ALU function and immediate for compute_op = alu; sampled with compute_cfg.";
        default sw = rw;
        default hw = r;
        field {
            desc = "Byte-wise ALU function (idma_pkg::alu_func_e).";
            encode = alu_func;
        } alu_func [3:0] = 0;
        field {
            desc = "8-bit immediate operand, broadcast to every byte lane.";
        } alu_imm [11:4] = 0;
        field {
            desc = "Reserved.";
        } reserved [31:12] = 0;
    };

    regfile dim {
        dst_stride dst_stride[SysAddrWidth/32];
        src_stride src_stride[SysAddrWidth/32];
        reps       reps[SysAddrWidth/32];
        ispresent = NumDims > 1;
    };

             conf     conf;
             status   status[16];
             next_id  next_id[16];
             done_id  done_id[16];
             dst_addr dst_addr[SysAddrWidth/32] @ 0xD0;
             src_addr src_addr[SysAddrWidth/32];
             length   length[SysAddrWidth/32];
             dim      dim[NumDims-1 | NumDims == 1];
             compute_cfg compute_cfg;
             compute_alu compute_alu;
};

`endif // IDMA_REG_RDL
